BJT differential-pair teaching study: noise-flicker
* Educational Gummel-Poon NPN, v1.0.0. Not a SKY130 model.
* Moderate beta/Early effect; finite diffusion and junction capacitances.
* Intrinsic RB/RC/RE=0 allows explicit hybrid-pi and noise reconstruction.
* TF=200 ps is an illustrative charge-storage parameter, not process data.
.model NPN_EDU NPN (IS=1e-15 BF=100 NF=1 VAF=100
+ BR=1 NR=1 VAR=100 RB=0 RC=0 RE=0
+ CJE=1p VJE=0.75 MJE=0.33 CJC=0.3p VJC=0.75 MJC=0.33
+ TF=200p TR=1n KF=1e-14 AF=1 TNOM=27)

* Teaching reconstruction of source topology. No PDK performance claim.
* voutn is Q1 collector; voutp is Q2 collector; X is Q3 collector.
Q1 voutn vinp e1 NPN_EDU
Q2 voutp vinn e2 NPN_EDU
Q3 x vb e3 NPN_EDU
RD1 vdd voutn 1k
RD2 vdd voutp 1k
R3 e1 x 50
R2 e2 x 50
R1 e3 vss 50
* Added equal per-output teaching loads, absent from the supplied schematic.
CL1 voutn vss 10p
CL2 voutp vss 10p

.temp 27
.options reltol=1e-7 abstol=1e-14 vntol=1e-10
VDD vdd 0 DC 3.3 AC 0
VSS vss 0 DC 0 AC 0
VB vb 0 DC 0.85 AC 0
VCM vcm 0 DC 1.8 AC 0
VDM dm 0 DC 0 AC 1
EINP vinp vcm dm 0 0.5
EINN vinn vcm dm 0 -0.5

.control
set noaskquit
set wr_vecnames
set wr_singlescale
noise v(voutp,voutn) VDM dec 100 1 10G
setplot noise1
wrdata noise-flicker.dat onoise_spectrum inoise_spectrum
quit
.endc
.end
