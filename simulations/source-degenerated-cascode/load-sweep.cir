Cascode load-sweep; each point recomputes bias and unit AC gain
.include models.lib
.include cascode-core.cir
.temp 27
.options reltol=1e-8 abstol=1e-15 vntol=1e-12
VDD vdd 0 1.8
VSS vss 0 0
VIN vin 0 DC 0.75 AC 1
VB vb 0 1.25
XDUT vdd vss vin out vb cascode RLVAL=10000 REVAL=50
CL out 0 1p
.control
set noaskquit
set wr_singlescale
set wr_vecnames
set numdgt=15
alter r.xdut.rl 50
op
wrdata load-sweep-0-op.dat v(out) v(xdut.e) v(xdut.x) i(VDD)
wrdata load-sweep-0-devices.dat @m.xdut.m1[id] @m.xdut.m1[gm] @m.xdut.m1[gds] @m.xdut.m1[gmbs] @m.xdut.m1[vgs] @m.xdut.m1[vds] @m.xdut.m1[von] @m.xdut.m1[vdsat] @m.xdut.m1[cgs] @m.xdut.m1[cgd] @m.xdut.m1[cgb] @m.xdut.m2[id] @m.xdut.m2[gm] @m.xdut.m2[gds] @m.xdut.m2[gmbs] @m.xdut.m2[vgs] @m.xdut.m2[vds] @m.xdut.m2[von] @m.xdut.m2[vdsat] @m.xdut.m2[cgs] @m.xdut.m2[cgd] @m.xdut.m2[cgb]
ac lin 1 1 1
wrdata load-sweep-0-ac.dat v(out)
alter r.xdut.rl 100
op
wrdata load-sweep-1-op.dat v(out) v(xdut.e) v(xdut.x) i(VDD)
wrdata load-sweep-1-devices.dat @m.xdut.m1[id] @m.xdut.m1[gm] @m.xdut.m1[gds] @m.xdut.m1[gmbs] @m.xdut.m1[vgs] @m.xdut.m1[vds] @m.xdut.m1[von] @m.xdut.m1[vdsat] @m.xdut.m1[cgs] @m.xdut.m1[cgd] @m.xdut.m1[cgb] @m.xdut.m2[id] @m.xdut.m2[gm] @m.xdut.m2[gds] @m.xdut.m2[gmbs] @m.xdut.m2[vgs] @m.xdut.m2[vds] @m.xdut.m2[von] @m.xdut.m2[vdsat] @m.xdut.m2[cgs] @m.xdut.m2[cgd] @m.xdut.m2[cgb]
ac lin 1 1 1
wrdata load-sweep-1-ac.dat v(out)
alter r.xdut.rl 200
op
wrdata load-sweep-2-op.dat v(out) v(xdut.e) v(xdut.x) i(VDD)
wrdata load-sweep-2-devices.dat @m.xdut.m1[id] @m.xdut.m1[gm] @m.xdut.m1[gds] @m.xdut.m1[gmbs] @m.xdut.m1[vgs] @m.xdut.m1[vds] @m.xdut.m1[von] @m.xdut.m1[vdsat] @m.xdut.m1[cgs] @m.xdut.m1[cgd] @m.xdut.m1[cgb] @m.xdut.m2[id] @m.xdut.m2[gm] @m.xdut.m2[gds] @m.xdut.m2[gmbs] @m.xdut.m2[vgs] @m.xdut.m2[vds] @m.xdut.m2[von] @m.xdut.m2[vdsat] @m.xdut.m2[cgs] @m.xdut.m2[cgd] @m.xdut.m2[cgb]
ac lin 1 1 1
wrdata load-sweep-2-ac.dat v(out)
alter r.xdut.rl 500
op
wrdata load-sweep-3-op.dat v(out) v(xdut.e) v(xdut.x) i(VDD)
wrdata load-sweep-3-devices.dat @m.xdut.m1[id] @m.xdut.m1[gm] @m.xdut.m1[gds] @m.xdut.m1[gmbs] @m.xdut.m1[vgs] @m.xdut.m1[vds] @m.xdut.m1[von] @m.xdut.m1[vdsat] @m.xdut.m1[cgs] @m.xdut.m1[cgd] @m.xdut.m1[cgb] @m.xdut.m2[id] @m.xdut.m2[gm] @m.xdut.m2[gds] @m.xdut.m2[gmbs] @m.xdut.m2[vgs] @m.xdut.m2[vds] @m.xdut.m2[von] @m.xdut.m2[vdsat] @m.xdut.m2[cgs] @m.xdut.m2[cgd] @m.xdut.m2[cgb]
ac lin 1 1 1
wrdata load-sweep-3-ac.dat v(out)
alter r.xdut.rl 1000
op
wrdata load-sweep-4-op.dat v(out) v(xdut.e) v(xdut.x) i(VDD)
wrdata load-sweep-4-devices.dat @m.xdut.m1[id] @m.xdut.m1[gm] @m.xdut.m1[gds] @m.xdut.m1[gmbs] @m.xdut.m1[vgs] @m.xdut.m1[vds] @m.xdut.m1[von] @m.xdut.m1[vdsat] @m.xdut.m1[cgs] @m.xdut.m1[cgd] @m.xdut.m1[cgb] @m.xdut.m2[id] @m.xdut.m2[gm] @m.xdut.m2[gds] @m.xdut.m2[gmbs] @m.xdut.m2[vgs] @m.xdut.m2[vds] @m.xdut.m2[von] @m.xdut.m2[vdsat] @m.xdut.m2[cgs] @m.xdut.m2[cgd] @m.xdut.m2[cgb]
ac lin 1 1 1
wrdata load-sweep-4-ac.dat v(out)
alter r.xdut.rl 2000
op
wrdata load-sweep-5-op.dat v(out) v(xdut.e) v(xdut.x) i(VDD)
wrdata load-sweep-5-devices.dat @m.xdut.m1[id] @m.xdut.m1[gm] @m.xdut.m1[gds] @m.xdut.m1[gmbs] @m.xdut.m1[vgs] @m.xdut.m1[vds] @m.xdut.m1[von] @m.xdut.m1[vdsat] @m.xdut.m1[cgs] @m.xdut.m1[cgd] @m.xdut.m1[cgb] @m.xdut.m2[id] @m.xdut.m2[gm] @m.xdut.m2[gds] @m.xdut.m2[gmbs] @m.xdut.m2[vgs] @m.xdut.m2[vds] @m.xdut.m2[von] @m.xdut.m2[vdsat] @m.xdut.m2[cgs] @m.xdut.m2[cgd] @m.xdut.m2[cgb]
ac lin 1 1 1
wrdata load-sweep-5-ac.dat v(out)
alter r.xdut.rl 5000
op
wrdata load-sweep-6-op.dat v(out) v(xdut.e) v(xdut.x) i(VDD)
wrdata load-sweep-6-devices.dat @m.xdut.m1[id] @m.xdut.m1[gm] @m.xdut.m1[gds] @m.xdut.m1[gmbs] @m.xdut.m1[vgs] @m.xdut.m1[vds] @m.xdut.m1[von] @m.xdut.m1[vdsat] @m.xdut.m1[cgs] @m.xdut.m1[cgd] @m.xdut.m1[cgb] @m.xdut.m2[id] @m.xdut.m2[gm] @m.xdut.m2[gds] @m.xdut.m2[gmbs] @m.xdut.m2[vgs] @m.xdut.m2[vds] @m.xdut.m2[von] @m.xdut.m2[vdsat] @m.xdut.m2[cgs] @m.xdut.m2[cgd] @m.xdut.m2[cgb]
ac lin 1 1 1
wrdata load-sweep-6-ac.dat v(out)
alter r.xdut.rl 10000
op
wrdata load-sweep-7-op.dat v(out) v(xdut.e) v(xdut.x) i(VDD)
wrdata load-sweep-7-devices.dat @m.xdut.m1[id] @m.xdut.m1[gm] @m.xdut.m1[gds] @m.xdut.m1[gmbs] @m.xdut.m1[vgs] @m.xdut.m1[vds] @m.xdut.m1[von] @m.xdut.m1[vdsat] @m.xdut.m1[cgs] @m.xdut.m1[cgd] @m.xdut.m1[cgb] @m.xdut.m2[id] @m.xdut.m2[gm] @m.xdut.m2[gds] @m.xdut.m2[gmbs] @m.xdut.m2[vgs] @m.xdut.m2[vds] @m.xdut.m2[von] @m.xdut.m2[vdsat] @m.xdut.m2[cgs] @m.xdut.m2[cgd] @m.xdut.m2[cgb]
ac lin 1 1 1
wrdata load-sweep-7-ac.dat v(out)
alter r.xdut.rl 15000
op
wrdata load-sweep-8-op.dat v(out) v(xdut.e) v(xdut.x) i(VDD)
wrdata load-sweep-8-devices.dat @m.xdut.m1[id] @m.xdut.m1[gm] @m.xdut.m1[gds] @m.xdut.m1[gmbs] @m.xdut.m1[vgs] @m.xdut.m1[vds] @m.xdut.m1[von] @m.xdut.m1[vdsat] @m.xdut.m1[cgs] @m.xdut.m1[cgd] @m.xdut.m1[cgb] @m.xdut.m2[id] @m.xdut.m2[gm] @m.xdut.m2[gds] @m.xdut.m2[gmbs] @m.xdut.m2[vgs] @m.xdut.m2[vds] @m.xdut.m2[von] @m.xdut.m2[vdsat] @m.xdut.m2[cgs] @m.xdut.m2[cgd] @m.xdut.m2[cgb]
ac lin 1 1 1
wrdata load-sweep-8-ac.dat v(out)
alter r.xdut.rl 20000
op
wrdata load-sweep-9-op.dat v(out) v(xdut.e) v(xdut.x) i(VDD)
wrdata load-sweep-9-devices.dat @m.xdut.m1[id] @m.xdut.m1[gm] @m.xdut.m1[gds] @m.xdut.m1[gmbs] @m.xdut.m1[vgs] @m.xdut.m1[vds] @m.xdut.m1[von] @m.xdut.m1[vdsat] @m.xdut.m1[cgs] @m.xdut.m1[cgd] @m.xdut.m1[cgb] @m.xdut.m2[id] @m.xdut.m2[gm] @m.xdut.m2[gds] @m.xdut.m2[gmbs] @m.xdut.m2[vgs] @m.xdut.m2[vds] @m.xdut.m2[von] @m.xdut.m2[vdsat] @m.xdut.m2[cgs] @m.xdut.m2[cgd] @m.xdut.m2[cgb]
ac lin 1 1 1
wrdata load-sweep-9-ac.dat v(out)
alter r.xdut.rl 25000
op
wrdata load-sweep-10-op.dat v(out) v(xdut.e) v(xdut.x) i(VDD)
wrdata load-sweep-10-devices.dat @m.xdut.m1[id] @m.xdut.m1[gm] @m.xdut.m1[gds] @m.xdut.m1[gmbs] @m.xdut.m1[vgs] @m.xdut.m1[vds] @m.xdut.m1[von] @m.xdut.m1[vdsat] @m.xdut.m1[cgs] @m.xdut.m1[cgd] @m.xdut.m1[cgb] @m.xdut.m2[id] @m.xdut.m2[gm] @m.xdut.m2[gds] @m.xdut.m2[gmbs] @m.xdut.m2[vgs] @m.xdut.m2[vds] @m.xdut.m2[von] @m.xdut.m2[vdsat] @m.xdut.m2[cgs] @m.xdut.m2[cgd] @m.xdut.m2[cgb]
ac lin 1 1 1
wrdata load-sweep-10-ac.dat v(out)
alter r.xdut.rl 30000
op
wrdata load-sweep-11-op.dat v(out) v(xdut.e) v(xdut.x) i(VDD)
wrdata load-sweep-11-devices.dat @m.xdut.m1[id] @m.xdut.m1[gm] @m.xdut.m1[gds] @m.xdut.m1[gmbs] @m.xdut.m1[vgs] @m.xdut.m1[vds] @m.xdut.m1[von] @m.xdut.m1[vdsat] @m.xdut.m1[cgs] @m.xdut.m1[cgd] @m.xdut.m1[cgb] @m.xdut.m2[id] @m.xdut.m2[gm] @m.xdut.m2[gds] @m.xdut.m2[gmbs] @m.xdut.m2[vgs] @m.xdut.m2[vds] @m.xdut.m2[von] @m.xdut.m2[vdsat] @m.xdut.m2[cgs] @m.xdut.m2[cgd] @m.xdut.m2[cgb]
ac lin 1 1 1
wrdata load-sweep-11-ac.dat v(out)
alter r.xdut.rl 40000
op
wrdata load-sweep-12-op.dat v(out) v(xdut.e) v(xdut.x) i(VDD)
wrdata load-sweep-12-devices.dat @m.xdut.m1[id] @m.xdut.m1[gm] @m.xdut.m1[gds] @m.xdut.m1[gmbs] @m.xdut.m1[vgs] @m.xdut.m1[vds] @m.xdut.m1[von] @m.xdut.m1[vdsat] @m.xdut.m1[cgs] @m.xdut.m1[cgd] @m.xdut.m1[cgb] @m.xdut.m2[id] @m.xdut.m2[gm] @m.xdut.m2[gds] @m.xdut.m2[gmbs] @m.xdut.m2[vgs] @m.xdut.m2[vds] @m.xdut.m2[von] @m.xdut.m2[vdsat] @m.xdut.m2[cgs] @m.xdut.m2[cgd] @m.xdut.m2[cgb]
ac lin 1 1 1
wrdata load-sweep-12-ac.dat v(out)
quit
.endc
.end
