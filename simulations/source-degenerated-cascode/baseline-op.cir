Cascode baseline: op; teaching LEVEL=1, not SKY130
.include models.lib
.include cascode-core.cir
.temp 27
.options reltol=1e-8 abstol=1e-15 vntol=1e-12
VDD vdd 0 DC 1.8
VSS vss 0 DC 0
VB vb 0 DC 1.25
VIN vin 0 DC 0.75
XDUT vdd vss vin out vb cascode RLVAL=50 REVAL=50
CL out 0 1p
.control
set noaskquit
set wr_singlescale
set wr_vecnames
set numdgt=15
op
show all
wrdata baseline-op.dat v(out) v(xdut.e) v(xdut.x) i(VDD)
wrdata baseline-devices.dat @m.xdut.m1[id] @m.xdut.m1[gm] @m.xdut.m1[gds] @m.xdut.m1[gmbs] @m.xdut.m1[vgs] @m.xdut.m1[vds] @m.xdut.m1[von] @m.xdut.m1[vdsat] @m.xdut.m1[cgs] @m.xdut.m1[cgd] @m.xdut.m1[cgb] @m.xdut.m2[id] @m.xdut.m2[gm] @m.xdut.m2[gds] @m.xdut.m2[gmbs] @m.xdut.m2[vgs] @m.xdut.m2[vds] @m.xdut.m2[von] @m.xdut.m2[vdsat] @m.xdut.m2[cgs] @m.xdut.m2[cgd] @m.xdut.m2[cgb]
wrdata baseline-model.dat @nmos_edu[tox] @nmos_edu[ld] @m.xdut.m1[w] @m.xdut.m1[l] @m.xdut.m2[w] @m.xdut.m2[l]
quit
.endc
.end
