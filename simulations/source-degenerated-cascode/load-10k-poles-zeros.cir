Cascode load-10k: poles-zeros; teaching LEVEL=1, not SKY130
.include models.lib
.include cascode-core.cir
.temp 27
.options reltol=1e-8 abstol=1e-15 vntol=1e-12
VDD vdd 0 DC 1.8
VSS vss 0 DC 0
VB vb 0 DC 1.25
VCM cm 0 0.75
RDC signal 0 1G
EIN vin cm signal 0 1
XDUT vdd vss vin out vb cascode RLVAL=10000 REVAL=50
CL out 0 1p
.control
set noaskquit
set wr_singlescale
set wr_vecnames
set numdgt=15
pz signal 0 out 0 vol pz
print all
quit
.endc
.end
