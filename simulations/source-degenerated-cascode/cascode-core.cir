* Generated by code/export_cascode.py; same D/G/S/B, W/L, R values.
* Global ground promoted to VSS port for negative-rail tests.
* RLVAL/REVAL overrides are explicit simulation experiments.
.subckt cascode VDD VSS VIN OUT VB params: RLVAL=50 REVAL=50
M1 X VIN E VSS NMOS_EDU w=1u l=150n m=1
M2 OUT VB X VSS NMOS_EDU w=1u l=150n m=1
RE E VSS {REVAL}
RL VDD OUT {RLVAL}
.ends cascode
