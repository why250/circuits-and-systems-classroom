.title KiCad schematic
.include "../models.lib"
.temp 27
.options reltol=1e-8 abstol=1e-15 vntol=1e-12
V3 /VB 0 DC 1.4
V1 /VDD 0 DC 1.8
V4 /VSS 0 DC 0
V2 /VIN 0 PULSE(0.85 0.8501 1e-08 2e-11 2e-11 2e-08 5e-08)
M1 /X /VIN /E /VSS NMOS_EDU m=10 l=150n w=1u
R2 /E /VSS 50
R1 /VDD /OUT 1000
C1 /OUT 0 1p
M2 /OUT /VB /X /VSS NMOS_EDU m=10 l=150n w=1u
.control
set wr_singlescale
set wr_vecnames
set numdgt=15
tran 1e-11 4e-08 0 1e-11
wrdata step.dat v(/VIN) v(/OUT)
quit
.endc
.end
