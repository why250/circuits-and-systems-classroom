5T OTA operating point and device parameters
.include models.lib
.include ota-core.cir
.temp 27
VDD vdd 0 1.8
VB vb 0 0.65
VINP vinp 0 0.9
VINN vinn 0 0.9
XDUT vdd 0 vinp vinn out vb ota_5t
CL out 0 1p
.control
set noaskquit
set wr_singlescale
set wr_vecnames
op
print v(out) v(xdut.x) v(xdut.y) i(VDD)
show all
wrdata op.dat v(out) v(xdut.x) v(xdut.y) i(VDD)
wrdata capacitances.dat @m.xdut.m1[cgs] @m.xdut.m1[cgd] @m.xdut.m1[cgb] @m.xdut.m2[cgs] @m.xdut.m2[cgd] @m.xdut.m2[cgb] @m.xdut.m3[cgs] @m.xdut.m3[cgd] @m.xdut.m3[cgb] @m.xdut.m4[cgs] @m.xdut.m4[cgd] @m.xdut.m4[cgb] @m.xdut.m5[cgs] @m.xdut.m5[cgd] @m.xdut.m5[cgb]
wrdata devices.dat @m.xdut.m1[id] @m.xdut.m1[gm] @m.xdut.m1[gds] @m.xdut.m1[gmbs] @m.xdut.m1[vgs] @m.xdut.m1[vds] @m.xdut.m1[von] @m.xdut.m1[vdsat] @m.xdut.m2[id] @m.xdut.m2[gm] @m.xdut.m2[gds] @m.xdut.m2[gmbs] @m.xdut.m2[vgs] @m.xdut.m2[vds] @m.xdut.m2[von] @m.xdut.m2[vdsat] @m.xdut.m3[id] @m.xdut.m3[gm] @m.xdut.m3[gds] @m.xdut.m3[gmbs] @m.xdut.m3[vgs] @m.xdut.m3[vds] @m.xdut.m3[von] @m.xdut.m3[vdsat] @m.xdut.m4[id] @m.xdut.m4[gm] @m.xdut.m4[gds] @m.xdut.m4[gmbs] @m.xdut.m4[vgs] @m.xdut.m4[vds] @m.xdut.m4[von] @m.xdut.m4[vdsat] @m.xdut.m5[id] @m.xdut.m5[gm] @m.xdut.m5[gds] @m.xdut.m5[gmbs] @m.xdut.m5[vgs] @m.xdut.m5[vds] @m.xdut.m5[von] @m.xdut.m5[vdsat]
quit
.endc
.end
