5T OTA common-mode gain; both inputs have unit AC amplitude
.include models.lib
.include ota-core.cir
.temp 27
VDD vdd 0 1.8
VB vb 0 0.65
VINP vinp 0 DC 0.9 AC 1 0
VINN vinn 0 DC 0.9 AC 1 0
XDUT vdd 0 vinp vinn out vb ota_5t
CL out 0 1p
.control
set noaskquit
set wr_singlescale
set wr_vecnames
ac dec 80 1 100G
let gain = v(out)/v(vinp)
let tail_gain = v(xdut.x)/v(vinp)
let mirror_gain = v(xdut.y)/v(vinp)
wrdata ac-common-mode.dat real(gain) imag(gain) real(tail_gain) imag(tail_gain) real(mirror_gain) imag(mirror_gain)
quit
.endc
.end
