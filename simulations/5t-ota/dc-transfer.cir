5T OTA balanced differential DC sweep at fixed common mode
.include models.lib
.include ota-core.cir
.temp 27
VDD vdd 0 1.8
VB vb 0 0.65
VDIFF diff 0 0
BPLUS vinp 0 V=0.9+v(diff)/2
BMINUS vinn 0 V=0.9-v(diff)/2
XDUT vdd 0 vinp vinn out vb ota_5t
CL out 0 1p
.control
set noaskquit
set wr_singlescale
set wr_vecnames
dc VDIFF -20m 20m 0.1m
wrdata dc-transfer.dat v(vinp) v(vinn) v(out)
quit
.endc
.end
