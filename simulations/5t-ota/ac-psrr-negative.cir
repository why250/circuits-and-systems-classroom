5T OTA negative-supply transfer; OUT, inputs, VB and CL refer to external ground
.include models.lib
.include ota-core.cir
.temp 27
VDD vdd 0 DC 1.8
VSS vss 0 DC 0 AC 1
VB vb 0 0.65
VINP vinp 0 0.9
VINN vinn 0 0.9
XDUT vdd vss vinp vinn out vb ota_5t
CL out 0 1p
.control
set noaskquit
set wr_singlescale
set wr_vecnames
ac dec 80 1 100G
let gain = v(out)/v(vss)
wrdata ac-psrr-negative.dat real(gain) imag(gain)
quit
.endc
.end
